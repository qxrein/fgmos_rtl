* NGSPICE file created from qfg_tlg_k9.ext - technology: sky130A

.subckt sky130_fd_pr__pfet_01v8_4SLV3C B D0 G S1 D2 S3 D4 S5 D6 S7 D8 S9 D10 S11 D12
+ S13 D14 S15 a_735_n364# VSUBS
X0 D4 G S3 B sky130_fd_pr__pfet_01v8 ad=0.66 pd=4.33 as=0.66 ps=4.33 w=4 l=0.15
X1 S15 G D14 B sky130_fd_pr__pfet_01v8 ad=0.66 pd=4.33 as=0.66 ps=4.33 w=4 l=0.15
X2 S1 G D0 B sky130_fd_pr__pfet_01v8 ad=0.66 pd=4.33 as=1.24 ps=8.62 w=4 l=0.15
X3 D8 G S7 B sky130_fd_pr__pfet_01v8 ad=0.66 pd=4.33 as=0.66 ps=4.33 w=4 l=0.15
X4 D12 G S11 B sky130_fd_pr__pfet_01v8 ad=0.66 pd=4.33 as=0.66 ps=4.33 w=4 l=0.15
X5 D2 G S1 B sky130_fd_pr__pfet_01v8 ad=0.66 pd=4.33 as=0.66 ps=4.33 w=4 l=0.15
X6 S11 G D10 B sky130_fd_pr__pfet_01v8 ad=0.66 pd=4.33 as=0.66 ps=4.33 w=4 l=0.15
X7 S5 G D4 B sky130_fd_pr__pfet_01v8 ad=0.66 pd=4.33 as=0.66 ps=4.33 w=4 l=0.15
X8 D14 G S13 B sky130_fd_pr__pfet_01v8 ad=0.66 pd=4.33 as=0.66 ps=4.33 w=4 l=0.15
X9 D10 G S9 B sky130_fd_pr__pfet_01v8 ad=0.66 pd=4.33 as=0.66 ps=4.33 w=4 l=0.15
X10 D6 G S5 B sky130_fd_pr__pfet_01v8 ad=0.66 pd=4.33 as=0.66 ps=4.33 w=4 l=0.15
X11 S13 G D12 B sky130_fd_pr__pfet_01v8 ad=0.66 pd=4.33 as=0.66 ps=4.33 w=4 l=0.15
X12 S3 G D2 B sky130_fd_pr__pfet_01v8 ad=0.66 pd=4.33 as=0.66 ps=4.33 w=4 l=0.15
X13 S9 G D8 B sky130_fd_pr__pfet_01v8 ad=0.66 pd=4.33 as=0.66 ps=4.33 w=4 l=0.15
X14 a_735_n364# G S15 B sky130_fd_pr__pfet_01v8 ad=1.24 pd=8.62 as=0.66 ps=4.33 w=4 l=0.15
X15 S7 G D6 B sky130_fd_pr__pfet_01v8 ad=0.66 pd=4.33 as=0.66 ps=4.33 w=4 l=0.15
C0 D10 S11 0.32431f
C1 D6 S7 0.32431f
C2 G D6 0.13243f
C3 B S7 0.06986f
C4 D2 S3 0.32431f
C5 G S15 0.13243f
C6 B G 1.91115f
C7 B D6 0.06986f
C8 G S5 0.13243f
C9 B S15 0.06062f
C10 G D14 0.13243f
C11 a_735_n364# G 0.06621f
C12 S9 D10 0.32431f
C13 S5 D6 0.32431f
C14 D14 S15 0.32431f
C15 G D4 0.13243f
C16 S1 D2 0.32431f
C17 B S5 0.06986f
C18 G S13 0.13243f
C19 a_735_n364# S15 0.32431f
C20 B D14 0.06986f
C21 a_735_n364# B 0.23251f
C22 G S11 0.13243f
C23 G S3 0.13243f
C24 B D4 0.06986f
C25 B S13 0.06986f
C26 G D12 0.13243f
C27 D8 S9 0.32431f
C28 G D10 0.13243f
C29 B S11 0.06986f
C30 D4 S5 0.32431f
C31 S13 D14 0.32431f
C32 D0 S1 0.32431f
C33 B S3 0.06986f
C34 G D2 0.13243f
C35 B D12 0.06986f
C36 B D10 0.06986f
C37 G S9 0.13243f
C38 G S1 0.13243f
C39 B D2 0.06986f
C40 S7 D8 0.32431f
C41 B S9 0.06986f
C42 S3 D4 0.32431f
C43 G D8 0.13243f
C44 D12 S13 0.32431f
C45 B S1 0.06062f
C46 G D0 0.06621f
C47 S11 D12 0.32431f
C48 G S7 0.13243f
C49 B D8 0.06986f
C50 B D0 0.23251f
C51 D4 VSUBS 0.25767f
C52 S3 VSUBS 0.25767f
C53 D0 VSUBS 0.11346f
C54 B VSUBS 7.60432f
C55 a_735_n364# VSUBS 0.11346f
.ends

.subckt sky130_fd_pr__nfet_01v8_EQ7N4B B D S G
X0 S G D B sky130_fd_pr__nfet_01v8 ad=0.1218 pd=1.42 as=0.1218 ps=1.42 w=0.42 l=0.5
C0 D S 0.02107f
C1 G S 0.01601f
C2 G D 0.01601f
C3 S B 0.19624f
C4 D B 0.19624f
.ends

.subckt sky130_fd_pr__nfet_01v8_M48NH5 B D S G
X0 S G D B sky130_fd_pr__nfet_01v8 ad=0.1218 pd=1.42 as=0.1218 ps=1.42 w=0.42 l=0.15
C0 D S 0.03727f
C1 G S 0.0114f
C2 G D 0.0114f
C3 S B 0.15854f
C4 D B 0.15854f
.ends

.subckt sky130_fd_pr__pfet_01v8_SEBX2B B D S G VSUBS
X0 S G D B sky130_fd_pr__pfet_01v8 ad=0.29 pd=2.58 as=0.29 ps=2.58 w=1 l=0.15
C0 B S 0.07936f
C1 G D 0.01944f
C2 B D 0.07936f
C3 B G 0.14608f
C4 D S 0.08701f
C5 G S 0.01944f
C6 S VSUBS 0.05867f
C7 D VSUBS 0.05867f
C8 B VSUBS 1.07672f
.ends

.subckt qfg_tlg_k9 I0 I1 I2 I3 I4 I5 I6 I7 I8 VB RST FG Y YB VDD VSS
XMP VDD VDD FG YB VDD YB VDD YB VDD YB VDD YB VDD YB VDD YB VDD YB VDD VSS sky130_fd_pr__pfet_01v8_4SLV3C
XMR VSS FG VB RST sky130_fd_pr__nfet_01v8_EQ7N4B
XMIN VSS Y VSS YB sky130_fd_pr__nfet_01v8_M48NH5
XMN0 VSS YB VSS I0 sky130_fd_pr__nfet_01v8_M48NH5
XMIP VDD Y VDD YB VSS sky130_fd_pr__pfet_01v8_SEBX2B
XMN1 VSS YB VSS I1 sky130_fd_pr__nfet_01v8_M48NH5
XMN2 VSS YB VSS I2 sky130_fd_pr__nfet_01v8_M48NH5
XMN3 VSS YB VSS I3 sky130_fd_pr__nfet_01v8_M48NH5
XMN4 VSS YB VSS I4 sky130_fd_pr__nfet_01v8_M48NH5
XMN6 VSS YB VSS I6 sky130_fd_pr__nfet_01v8_M48NH5
XMN5 VSS YB VSS I5 sky130_fd_pr__nfet_01v8_M48NH5
XMN7 VSS YB VSS I7 sky130_fd_pr__nfet_01v8_M48NH5
XMN8 VSS YB VSS I8 sky130_fd_pr__nfet_01v8_M48NH5
X0 FG I3 sky130_fd_pr__cap_mim_m3_1 l=2 w=2
X1 FG I2 sky130_fd_pr__cap_mim_m3_1 l=2 w=2
X2 FG I8 sky130_fd_pr__cap_mim_m3_1 l=2 w=2
X3 FG I0 sky130_fd_pr__cap_mim_m3_1 l=2 w=2
X4 FG I1 sky130_fd_pr__cap_mim_m3_1 l=2 w=2
X5 FG I4 sky130_fd_pr__cap_mim_m3_1 l=2 w=2
X6 FG I5 sky130_fd_pr__cap_mim_m3_1 l=2 w=2
X7 FG I6 sky130_fd_pr__cap_mim_m3_1 l=2 w=2
X8 FG I7 sky130_fd_pr__cap_mim_m3_1 l=2 w=2
X9 FG VSS sky130_fd_pr__cap_mim_m3_1 l=2.08 w=9.2
C0 RST Y 0.00232f
C1 VDD FG 0.19252f
C2 FG I8 0.56374f
C3 FG I5 0.59694f
C4 FG I4 0.59694f
C5 FG I2 0.62367f
C6 FG Y 0.00933f
C7 VDD I8 0
C8 VDD I5 0
C9 VDD I4 0
C10 VDD I2 0.0261f
C11 VB YB 0.02622f
C12 I6 I7 0.08252f
C13 I4 I5 0.08252f
C14 VDD Y 0.05753f
C15 YB I7 0.05812f
C16 Y I8 0
C17 YB I6 0.05807f
C18 YB I3 0.05807f
C19 YB I1 0.06701f
C20 RST VB 0.0042f
C21 I0 I1 0.08252f
C22 I0 YB 0.05821f
C23 RST YB 0.03202f
C24 FG VB 0.02539f
C25 FG I7 0.59722f
C26 FG I6 0.59694f
C27 FG I3 0.59852f
C28 FG I1 0.72392f
C29 FG YB 0.72826f
C30 VDD I7 0
C31 VDD I6 0
C32 I7 I8 0.08252f
C33 VDD I3 0
C34 VDD I1 0.01777f
C35 VB Y 0.02081f
C36 I6 I5 0.08252f
C37 FG I0 0.56332f
C38 VDD YB 0.69106f
C39 FG RST 0.01067f
C40 I3 I4 0.08252f
C41 YB I8 0.05434f
C42 I2 I3 0.08252f
C43 YB I5 0.05807f
C44 Y I7 0
C45 I1 I2 0.08252f
C46 YB I4 0.05807f
C47 YB I2 0.06164f
C48 Y YB 0.16595f
C49 VDD I0 0.02963f
C50 VDD RST 0
C51 RST I8 0.01775f
C52 I8 VSS 0.57412f
C53 I7 VSS 0.48582f
C54 I5 VSS 0.48582f
C55 I6 VSS 0.48582f
C56 I4 VSS 0.48582f
C57 I3 VSS 4.62643f
C58 I2 VSS 0.41825f
C59 I1 VSS 0.41072f
C60 YB VSS 4.84073f
C61 I0 VSS 0.62375f
C62 Y VSS 0.28794f
C63 VB VSS 0.0159f
C64 RST VSS 0.0138f
C65 VDD VSS 1.86207f
.ends
