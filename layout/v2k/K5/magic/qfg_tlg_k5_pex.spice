* NGSPICE file created from qfg_tlg_k5.ext - technology: sky130A

.subckt sky130_fd_pr__pfet_01v8_DC2PY3 B D0 G S1 D2 S3 D4 S5 D6 S7 a_351_n364# VSUBS
X0 D4 G S3 B sky130_fd_pr__pfet_01v8 ad=0.66 pd=4.33 as=0.66 ps=4.33 w=4 l=0.15
X1 a_351_n364# G S7 B sky130_fd_pr__pfet_01v8 ad=1.24 pd=8.62 as=0.66 ps=4.33 w=4 l=0.15
X2 S7 G D6 B sky130_fd_pr__pfet_01v8 ad=0.66 pd=4.33 as=0.66 ps=4.33 w=4 l=0.15
X3 S1 G D0 B sky130_fd_pr__pfet_01v8 ad=0.66 pd=4.33 as=1.24 ps=8.62 w=4 l=0.15
X4 D6 G S5 B sky130_fd_pr__pfet_01v8 ad=0.66 pd=4.33 as=0.66 ps=4.33 w=4 l=0.15
X5 D2 G S1 B sky130_fd_pr__pfet_01v8 ad=0.66 pd=4.33 as=0.66 ps=4.33 w=4 l=0.15
X6 S5 G D4 B sky130_fd_pr__pfet_01v8 ad=0.66 pd=4.33 as=0.66 ps=4.33 w=4 l=0.15
X7 S3 G D2 B sky130_fd_pr__pfet_01v8 ad=0.66 pd=4.33 as=0.66 ps=4.33 w=4 l=0.15
C0 D6 S7 0.32431f
C1 G D6 0.13243f
C2 B S7 0.06986f
C3 D2 S3 0.32431f
C4 B G 0.99734f
C5 a_351_n364# S7 0.32431f
C6 G S5 0.13243f
C7 B D6 0.06986f
C8 a_351_n364# G 0.06621f
C9 S5 D6 0.32431f
C10 G D4 0.13243f
C11 B S5 0.06986f
C12 S1 D2 0.32431f
C13 a_351_n364# B 0.23251f
C14 B D4 0.06986f
C15 G S3 0.13243f
C16 D4 S5 0.32431f
C17 D0 S1 0.32431f
C18 G D2 0.13243f
C19 B S3 0.06986f
C20 G S1 0.13243f
C21 B D2 0.06986f
C22 S3 D4 0.32431f
C23 B S1 0.06986f
C24 G D0 0.06621f
C25 G S7 0.13243f
C26 B D0 0.23251f
C27 D4 VSUBS 0.13605f
C28 S3 VSUBS 0.13605f
C29 D0 VSUBS 0.11346f
C30 B VSUBS 4.63739f
C31 a_351_n364# VSUBS 0.11346f
.ends

.subckt sky130_fd_pr__nfet_01v8_EQ7N4B B D S G
X0 S G D B sky130_fd_pr__nfet_01v8 ad=0.1218 pd=1.42 as=0.1218 ps=1.42 w=0.42 l=0.5
C0 D S 0.02107f
C1 G S 0.01601f
C2 G D 0.01601f
C3 S B 0.19624f
C4 D B 0.19624f
.ends

.subckt sky130_fd_pr__nfet_01v8_M48NH5 B D S G
X0 S G D B sky130_fd_pr__nfet_01v8 ad=0.1218 pd=1.42 as=0.1218 ps=1.42 w=0.42 l=0.15
C0 G D 0.0114f
C1 D S 0.03727f
C2 G S 0.0114f
C3 S B 0.15854f
C4 D B 0.15854f
.ends

.subckt sky130_fd_pr__pfet_01v8_SEBX2B B D S G VSUBS
X0 S G D B sky130_fd_pr__pfet_01v8 ad=0.29 pd=2.58 as=0.29 ps=2.58 w=1 l=0.15
C0 B S 0.07936f
C1 G D 0.01944f
C2 B D 0.07936f
C3 B G 0.14608f
C4 D S 0.08701f
C5 G S 0.01944f
C6 S VSUBS 0.05867f
C7 D VSUBS 0.05867f
C8 B VSUBS 1.07672f
.ends

.subckt qfg_tlg_k5 I0 I1 I2 I3 I4 VB RST FG Y YB VDD VSS
XMP VDD VDD FG YB VDD YB VDD YB VDD YB VDD VSS sky130_fd_pr__pfet_01v8_DC2PY3
XMR VSS FG VB RST sky130_fd_pr__nfet_01v8_EQ7N4B
XMIN VSS Y VSS YB sky130_fd_pr__nfet_01v8_M48NH5
XMN0 VSS YB VSS I0 sky130_fd_pr__nfet_01v8_M48NH5
XMIP VDD Y VDD YB VSS sky130_fd_pr__pfet_01v8_SEBX2B
XMN1 VSS YB VSS I1 sky130_fd_pr__nfet_01v8_M48NH5
XMN2 VSS YB VSS I2 sky130_fd_pr__nfet_01v8_M48NH5
XMN3 VSS YB VSS I3 sky130_fd_pr__nfet_01v8_M48NH5
XMN4 VSS YB VSS I4 sky130_fd_pr__nfet_01v8_M48NH5
X0 FG I3 sky130_fd_pr__cap_mim_m3_1 l=2 w=2
X1 FG I2 sky130_fd_pr__cap_mim_m3_1 l=2 w=2
X2 FG I0 sky130_fd_pr__cap_mim_m3_1 l=2 w=2
X3 FG I1 sky130_fd_pr__cap_mim_m3_1 l=2 w=2
X4 FG I4 sky130_fd_pr__cap_mim_m3_1 l=2 w=2
X5 FG VSS sky130_fd_pr__cap_mim_m3_1 l=2 w=9.2
C0 I0 I1 0.08252f
C1 YB I3 0.05812f
C2 YB I1 0.06112f
C3 VB Y 0.02081f
C4 YB I0 0.05821f
C5 YB RST 0.03202f
C6 FG VB 0.02539f
C7 Y I3 0
C8 FG I3 0.59727f
C9 FG I1 0.65549f
C10 I3 I4 0.08252f
C11 I2 I3 0.08252f
C12 I1 I2 0.08252f
C13 VDD I3 0
C14 RST Y 0.00232f
C15 VDD I1 0.02392f
C16 YB Y 0.16595f
C17 FG I0 0.64375f
C18 FG RST 0.01067f
C19 FG YB 0.45583f
C20 RST I4 0.01775f
C21 YB I4 0.05434f
C22 YB I2 0.05807f
C23 VDD I0 0.02963f
C24 VDD RST 0
C25 VDD YB 0.4029f
C26 FG Y 0.00933f
C27 Y I4 0
C28 FG I4 0.56374f
C29 FG I2 0.60469f
C30 VDD Y 0.05753f
C31 VDD FG 0.12533f
C32 VDD I4 0
C33 VDD I2 0
C34 RST VB 0.0042f
C35 YB VB 0.02622f
C36 I4 VSS 0.57412f
C37 I3 VSS 4.36521f
C38 I2 VSS 0.45657f
C39 I1 VSS 0.42476f
C40 Y VSS 0.28794f
C41 I0 VSS 0.6231f
C42 VB VSS 0.0159f
C43 RST VSS 0.0138f
C44 YB VSS 2.91573f
C45 VDD VSS 1.17179f
.ends
