* NGSPICE file created from qfg_tlg.ext - technology: sky130A

.subckt sky130_fd_pr__pfet_01v8_V7R9RB B D0 G S1 D2 S3 a_159_n364# VSUBS
X0 D2 G S1 B sky130_fd_pr__pfet_01v8 ad=0.66 pd=4.33 as=0.66 ps=4.33 w=4 l=0.15
X1 a_159_n364# G S3 B sky130_fd_pr__pfet_01v8 ad=1.24 pd=8.62 as=0.66 ps=4.33 w=4 l=0.15
X2 S3 G D2 B sky130_fd_pr__pfet_01v8 ad=0.66 pd=4.33 as=0.66 ps=4.33 w=4 l=0.15
X3 S1 G D0 B sky130_fd_pr__pfet_01v8 ad=0.66 pd=4.33 as=1.24 ps=8.62 w=4 l=0.15
C0 D2 S3 0.32431f
C1 B G 0.53053f
C2 a_159_n364# G 0.06621f
C3 S1 D2 0.32431f
C4 a_159_n364# B 0.24024f
C5 G S3 0.13243f
C6 B S3 0.06986f
C7 G D2 0.13243f
C8 D0 S1 0.32431f
C9 G S1 0.13243f
C10 B D2 0.06986f
C11 a_159_n364# S3 0.32431f
C12 B S1 0.06986f
C13 G D0 0.06621f
C14 B D0 0.24024f
C15 D2 VSUBS 0.07635f
C16 S1 VSUBS 0.07635f
C17 D0 VSUBS 0.10645f
C18 B VSUBS 3.16618f
C19 a_159_n364# VSUBS 0.10645f
.ends

.subckt sky130_fd_pr__nfet_01v8_EQ7N4B B D S G
X0 S G D B sky130_fd_pr__nfet_01v8 ad=0.1218 pd=1.42 as=0.1218 ps=1.42 w=0.42 l=0.5
C0 D S 0.02107f
C1 G S 0.01601f
C2 G D 0.01601f
C3 S B 0.19624f
C4 D B 0.19624f
.ends

.subckt sky130_fd_pr__nfet_01v8_M48NH5 B D S G
X0 S G D B sky130_fd_pr__nfet_01v8 ad=0.1218 pd=1.42 as=0.1218 ps=1.42 w=0.42 l=0.15
C0 D S 0.03727f
C1 G S 0.0114f
C2 G D 0.0114f
C3 S B 0.15854f
C4 D B 0.15854f
.ends

.subckt sky130_fd_pr__pfet_01v8_SEBX2B B D S G VSUBS
X0 S G D B sky130_fd_pr__pfet_01v8 ad=0.29 pd=2.58 as=0.29 ps=2.58 w=1 l=0.15
C0 B S 0.07936f
C1 G D 0.01944f
C2 B D 0.07936f
C3 B G 0.14608f
C4 D S 0.08701f
C5 G S 0.01944f
C6 S VSUBS 0.05867f
C7 D VSUBS 0.05867f
C8 B VSUBS 1.07672f
.ends

.subckt qfg_tlg A B C VB RST FG Y YB VDD VSS
XMP VDD VDD FG YB VDD YB VDD VSS sky130_fd_pr__pfet_01v8_V7R9RB
XMR VSS FG VB RST sky130_fd_pr__nfet_01v8_EQ7N4B
XMIN VSS Y VSS YB sky130_fd_pr__nfet_01v8_M48NH5
XMIP VDD Y VDD YB VSS sky130_fd_pr__pfet_01v8_SEBX2B
XMNA VSS YB VSS A sky130_fd_pr__nfet_01v8_M48NH5
XMNB VSS YB VSS B sky130_fd_pr__nfet_01v8_M48NH5
XMNC VSS YB VSS C sky130_fd_pr__nfet_01v8_M48NH5
X0 FG C sky130_fd_pr__cap_mim_m3_1 l=2 w=2
X1 FG A sky130_fd_pr__cap_mim_m3_1 l=2 w=2
X2 FG B sky130_fd_pr__cap_mim_m3_1 l=2 w=2
X3 FG VSS sky130_fd_pr__cap_mim_m3_1 l=2.55 w=9.2
C0 FG VB 0.02606f
C1 VB B 0
C2 FG Y 0.01478f
C3 Y VDD 0.08316f
C4 Y B 0.02251f
C5 RST VB 0.0042f
C6 FG VDD 0.09472f
C7 FG B 0.51095f
C8 RST Y 0.0015f
C9 B VDD 0.00806f
C10 RST FG 0.01807f
C11 RST VDD 0.00566f
C12 RST B 0.01413f
C13 YB C 0.04422f
C14 YB A 0.05119f
C15 Y C 0
C16 Y A 0
C17 YB VB 0.0441f
C18 FG C 0.49005f
C19 FG A 0.65202f
C20 YB Y 0.188f
C21 B C 0.07595f
C22 A VDD 0.02211f
C23 A B 0.07573f
C24 YB FG 0.27199f
C25 YB VDD 0.28775f
C26 YB B 0.08024f
C27 RST A 0.01775f
C28 YB RST 0.01787f
C29 VB Y 0
C30 VDD VSS 0.1516f
C31 C VSS 4.44175f
C32 B VSS 0.42655f
C33 A VSS 0.60844f
C34 Y VSS 0.23525f
C35 VB VSS 0.01719f
C36 RST VSS 0.00929f
C37 YB VSS 1.25007f
.ends
