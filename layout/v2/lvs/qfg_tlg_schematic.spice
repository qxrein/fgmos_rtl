* schematic netlist of the v2 cell (generated from sim/v2/ngs.py)

.subckt qfg_tlg A B C RST VB Y YB FG VDD VSS
XMP  YB FG VDD VDD sky130_fd_pr__pfet_01v8 W=16.0 L=0.15
XMNI0 YB A VSS VSS sky130_fd_pr__nfet_01v8 W=0.42 L=0.15
XMNI1 YB B VSS VSS sky130_fd_pr__nfet_01v8 W=0.42 L=0.15
XMNI2 YB C VSS VSS sky130_fd_pr__nfet_01v8 W=0.42 L=0.15
XCI0 FG A sky130_fd_pr__cap_mim_m3_1 W=2.0 L=2.0 MF=1
XCI1 FG B sky130_fd_pr__cap_mim_m3_1 W=2.0 L=2.0 MF=1
XCI2 FG C sky130_fd_pr__cap_mim_m3_1 W=2.0 L=2.0 MF=1
XCBL FG VSS sky130_fd_pr__cap_mim_m3_1 W=9.2 L=2.55 MF=1
XMR  FG RST VB VSS sky130_fd_pr__nfet_01v8 W=0.42 L=0.5
XIP  Y  YB VDD VDD sky130_fd_pr__pfet_01v8 W=1.0 L=0.15
XIN  Y  YB VSS VSS sky130_fd_pr__nfet_01v8 W=0.42 L=0.15
.ends qfg_tlg
