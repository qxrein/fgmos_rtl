* Sky130 TT corner parameters (standalone — no PDK installation needed)
* Extracted from sky130_fd_pr tt corner for nfet_01v8
.param VTH0_N  = 0.49
.param KN      = 270e-6
.param W_NFET  = 2e-6
.param L_NFET  = 0.15e-6
.param VCC     = 1.8
.param TEMP    = 27
.param CT_FG   = 40e-15    ;* C1+C2+C3+CFG+CSB+CDB (full FG node capacitance)
.param C1      = 10e-15
.param C2      = 10e-15
.param C3      = 10e-15
.param CFG     = 5e-15
.param CSB     = 3e-15
.param CDB     = 2e-15
